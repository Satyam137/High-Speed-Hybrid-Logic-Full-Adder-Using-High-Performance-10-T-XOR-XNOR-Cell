ADE simulation setup
Run mode: Single Run, Sweeps and Corners
Tests:
  ramkushal_FA_4_1: ramkushal/FA_4/schematic, simulator spectre
    Outputs: tpd; PDP
