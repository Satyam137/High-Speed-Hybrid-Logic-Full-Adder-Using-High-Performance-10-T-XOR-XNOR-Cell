ADE simulation setup
Run mode: Single Run, Sweeps and Corners
Tests:
  ramkushal_FA_3_1: ramkushal/FA_3/schematic, simulator spectre
    Outputs: tpd; PDP
