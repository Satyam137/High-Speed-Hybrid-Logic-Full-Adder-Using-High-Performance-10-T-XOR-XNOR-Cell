ADE simulation setup
Run mode: Single Run, Sweeps and Corners
Tests:
  ramkushal_cout_a_1: ramkushal/cout_a/schematic, simulator spectre
