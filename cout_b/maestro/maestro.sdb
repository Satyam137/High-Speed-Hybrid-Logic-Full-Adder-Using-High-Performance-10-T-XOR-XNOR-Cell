ADE simulation setup
Run mode: Single Run, Sweeps and Corners
Tests:
  ramkushal_cout_b_1: ramkushal/cout_b/schematic, simulator spectre
