ADE simulation setup
Test ramkushal_cout_b_1: ramkushal/cout_b/schematic, simulator spectre
  Models: /mnt/cadence_tools/gpdk090_v4.6/libs.oa22/gpdk090/../../models/spectre/gpdk090.scs[NN]
  Temperature: 27
  Stimulus Abar: voltage dc dc=1.8 srcType=dc
  Stimulus Cbar: voltage dc dc=1.8 srcType=dc
  Stimulus XOR: voltage dc dc=0 srcType=dc
  Stimulus XNOR: voltage dc dc=1.8 srcType=dc
  Stimulus Vdd!: voltage dc dc=1.8 srcType=dc
  Analysis tran: stop=10n
  Signals: /Cout, /Z, /Abar, /Cbar
Run mode: Single Run, Sweeps and Corners
