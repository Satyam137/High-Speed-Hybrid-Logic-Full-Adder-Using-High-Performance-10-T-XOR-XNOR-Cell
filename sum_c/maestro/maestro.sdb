ADE simulation setup
Run mode: Single Run, Sweeps and Corners
Tests:
  ramkushal_sum_c_1: ramkushal/sum_c/schematic, simulator spectre
