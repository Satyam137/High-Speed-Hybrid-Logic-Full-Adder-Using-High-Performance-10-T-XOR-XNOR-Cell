ADE simulation setup
Run mode: Single Run, Sweeps and Corners
Tests:
  ramkushal_sum_a_1: ramkushal/sum_a/schematic, simulator spectre
