ADE simulation setup
Run mode: Single Run, Sweeps and Corners
Tests:
  ramkushal_FA_1_1: ramkushal/FA_1/schematic, simulator spectre
    Outputs: tpd; PDP
