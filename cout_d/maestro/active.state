ADE simulation setup
Test ramkushal_cout_d_1: ramkushal/cout_d/schematic, simulator spectre
  Models: /mnt/cadence_tools/gpdk090_v4.6/libs.oa22/gpdk090/../../models/spectre/gpdk090.scs[NN], /mnt/cadence_tools/gpdk045_v_6_0/gpdk045/../models/spectre/gpdk045.scs[mc]
  Temperature: 27
  Stimulus Vdd!: voltage dc dc=1 srcType=dc
Run mode: Single Run, Sweeps and Corners
