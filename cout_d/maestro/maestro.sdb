ADE simulation setup
Run mode: Single Run, Sweeps and Corners
Tests:
  ramkushal_cout_d_1: ramkushal/cout_d/schematic, simulator spectre
