ADE simulation setup
Run mode: Single Run, Sweeps and Corners
Tests:
  ramkushal_FA_2_1: ramkushal/FA_2/schematic, simulator spectre
    Outputs: tpd; PDP
