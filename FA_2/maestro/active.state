ADE simulation setup
Test ramkushal_FA_2_1: ramkushal/FA_2/schematic, simulator spectre
  Models: /mnt/cadence_tools/gpdk090_v4.6/libs.oa22/gpdk090/../../models/spectre/gpdk090.scs[NN]
  Temperature: 27
  Stimulus A: voltage pulse dc=0 val0=0 val1=1.8 period=4n delay=0 srcType=pulse
  Stimulus B: voltage pulse dc=1.8 val0=0 val1=1.8 period=2n delay=0 srcType=pulse
  Stimulus Cin: voltage pulse val0=0 val1=1.8 period=1n delay=0 srcType=pulse
  Stimulus Vdd!: voltage dc dc=1.8 srcType=dc
  Analysis tran: stop=10n
  Output tpdr = delay(?wf1 VT("/A") ?value1 0.9 ?edge1 "rising" ?nth1 1 ?td1 0.0 ?tol1 nil ?wf2 VT("/Sum") ?value2 0.9 ?edge2 "falling" ?nth2 1 ?tol2 nil ?td2 nil ?stop nil ?multiple nil) (unticked)
  Output tpdf = delay(?wf1 VT("/A") ?value1 0.9 ?edge1 "falling" ?nth1 1 ?td1 0.0 ?tol1 nil ?wf2 VT("/Sum") ?value2 0.9 ?edge2 "rising" ?nth2 1 ?tol2 nil ?td2 nil ?stop nil ?multiple nil) (unticked)
  Output tpd = ((tpdf + tpdr) / 2) (unticked)
  Output Power = average(getData(":pwr" ?result "tran"))
  Output PDP = (Power * TRF)
  Output trf = delay(?wf1 VT("/B") ?value1 0.9 ?edge1 "rising" ?nth1 1 ?td1 0.0 ?tol1 nil ?wf2 VT("/Sum") ?value2 0.9 ?edge2 "falling" ?nth2 1 ?tol2 nil ?td2 nil ?stop nil ?multiple nil) (unticked)
  Output TRF = delay(?wf1 VT("/Cin") ?value1 0.9 ?edge1 "rising" ?nth1 1 ?td1 0.0 ?tol1 nil ?wf2 VT("/Cout") ?value2 0.9 ?edge2 "falling" ?nth2 1 ?tol2 nil ?td2 nil ?stop nil ?multiple nil)
  Signals: /Sum, /Cout, /net4, /net1, /A, /B, /Cin
Run mode: Single Run, Sweeps and Corners
