ADE simulation setup
Run mode: Single Run, Sweeps and Corners
Tests:
  ramkushal_cout_c_1: ramkushal/cout_c/schematic, simulator spectre
