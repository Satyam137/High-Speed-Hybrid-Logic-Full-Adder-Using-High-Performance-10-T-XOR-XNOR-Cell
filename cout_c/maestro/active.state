ADE simulation setup
Test ramkushal_cout_c_1: ramkushal/cout_c/schematic, simulator spectre
  Models: /mnt/cadence_tools/gpdk090_v4.6/libs.oa22/gpdk090/../../models/spectre/gpdk090.scs[NN]
  Temperature: 27
  Stimulus Abar: voltage dc dc=1.8 srcType=dc
  Stimulus Cbar: voltage dc dc=0 srcType=dc
  Stimulus XOR: voltage dc dc=0 srcType=dc
  Stimulus XNOR: voltage dc dc=1.8 srcType=dc
  Stimulus Vdd!: voltage dc dc=1.8 srcType=dc
  Analysis tran: stop=10n
  Signals: /net3, /net9, /Cout
Run mode: Single Run, Sweeps and Corners
