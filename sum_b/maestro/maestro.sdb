ADE simulation setup
Run mode: Single Run, Sweeps and Corners
Tests:
  ramkushal_sum_b_1: ramkushal/sum_b/schematic, simulator spectre
